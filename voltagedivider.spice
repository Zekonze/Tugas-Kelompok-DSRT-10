** sch_path: /headless/Desktop/DSRT SEM6/voltagedivider.sch
.subckt voltagedivider vdd vss out
*.PININFO vdd:I vss:I out:O
XC1 net1 net2 sky130_fd_pr__cap_mim_m3_1 W=224 L=224
R4 net2 net1 sky130_fd_pr__res_generic_l1 W=1.2 L=21.6
XM1 out net30 net1 GND sky130_fd_pr__nfet_03v3_nvt L=0.5 W=1 nf=1
*XR5 net31 vdd vss sky130_fd_pr__res_xhigh_po W=0.35 L=47.5 mult=1
*XR1 net12 net30 vss sky130_fd_pr__res_xhigh_po W=0.35 L=47.5 mult=1
R2 net15 vdd sky130_fd_pr__res_generic_l1 W=1.2 L=41.8
*XR6 net3 net31 vss sky130_fd_pr__res_xhigh_po W=0.35 L=47.5 mult=1
*XR7 net5 net4 vss sky130_fd_pr__res_xhigh_po W=0.35 L=47.5 mult=1
*XR8 net4 net3 vss sky130_fd_pr__res_xhigh_po W=0.35 L=47.5 mult=1
*XR9 net6 net5 vss sky130_fd_pr__res_xhigh_po W=0.35 L=47.5 mult=1
*XR10 net7 net6 vss sky130_fd_pr__res_xhigh_po W=0.35 L=47.5 mult=1
*XR11 net9 net8 vss sky130_fd_pr__res_xhigh_po W=0.35 L=47.5 mult=1
*XR12 net8 net7 vss sky130_fd_pr__res_xhigh_po W=0.35 L=47.5 mult=1
*XR13 net10 net9 vss sky130_fd_pr__res_xhigh_po W=0.35 L=47.5 mult=1
*XR14 net11 net10 vss sky130_fd_pr__res_xhigh_po W=0.35 L=47.5 mult=1
*XR15 net30 net11 vss sky130_fd_pr__res_xhigh_po W=0.35 L=47.5 mult=1
*XR16 net13 net12 vss sky130_fd_pr__res_xhigh_po W=0.35 L=47.5 mult=1
*XR17 vss net14 vss sky130_fd_pr__res_xhigh_po W=0.35 L=47.5 mult=1
*XR18 net14 net13 vss sky130_fd_pr__res_xhigh_po W=0.35 L=47.5 mult=1
R19 net16 net15 sky130_fd_pr__res_generic_l1 W=1.2 L=41.8
R20 net18 net17 sky130_fd_pr__res_generic_l1 W=1.2 L=41.8
R21 net17 net16 sky130_fd_pr__res_generic_l1 W=1.2 L=41.8
R22 net19 net18 sky130_fd_pr__res_generic_l1 W=1.2 L=41.8
R23 net20 net19 sky130_fd_pr__res_generic_l1 W=1.2 L=41.8
R24 net22 net21 sky130_fd_pr__res_generic_l1 W=1.2 L=41.8
R25 net21 net20 sky130_fd_pr__res_generic_l1 W=1.2 L=41.8
R26 net23 net22 sky130_fd_pr__res_generic_l1 W=1.2 L=41.8
R27 net24 net23 sky130_fd_pr__res_generic_l1 W=1.2 L=41.8
R28 net26 net25 sky130_fd_pr__res_generic_l1 W=1.2 L=41.8
R29 net25 net24 sky130_fd_pr__res_generic_l1 W=1.2 L=41.8
R30 net27 net26 sky130_fd_pr__res_generic_l1 W=1.2 L=41.8
R31 net28 net27 sky130_fd_pr__res_generic_l1 W=1.2 L=41.8
R32 out net29 sky130_fd_pr__res_generic_l1 W=1.2 L=41.8
R33 net29 net28 sky130_fd_pr__res_generic_l1 W=1.2 L=41.8
.ends
